* Measure statements for pass/fail verification
.meas tran clk2q_delay TRIG v(clk) VAL=0.9 RISE=1 TD=19.0n TARG v(Q) VAL=0.9 RISE=1 TD=19.0n
